ADE simulation setup
Run mode: Single Run, Sweeps and Corners
Tests:
  DLDO_final: DLDO_final/DLDO_implementation/config, simulator ams
    Variables: wireopt = 211; current = 500u; Lswitch = 300n; Ltop = 1.4u; R = 0.1; R1 = 250; R2 = 1k; T = 1n; vref = 1; Wswitch = 32u; Wtop = 32u; vindc = 3; open = 30; close = 40
