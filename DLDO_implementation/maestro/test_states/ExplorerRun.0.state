ADE simulation setup
Test DLDO_final: DLDO_final/DLDO_implementation/config, simulator ams
  Models: /data/ibm/bicmos8hp/V1.6.0.0HP/Spectre/models/allModels.scs[tt], /data/ibm/bicmos8hp/V1.6.0.0HP/Spectre/models/design.scs, /data/ibm/bicmos8hp/V1.6.0.0HP/Spectre/models/wafer.scs
  Variables: wireopt = 211; current = 500u; Lswitch = 300n; Ltop = 1.4u; R = 0.1; R1 = 250; R2 = 1k; T = 1n; vref = 1; Wswitch = 32u; Wtop = 32u; vindc = 2; open = 80; close = 80
  Temperature: 27
  Analysis tran: stop=4u
  Analysis dc: (saves the operating point)
  Output Current on Load Resistor = itime('tran "/R6/PLUS") (unticked)
  Signals: /vout, /vfeedback, /net3, /vref<7:0>, /vin<7:0>, /hl, /CLK, /pulse, /adcclk, /in<7:0>, /R6/PLUS (terminal)
