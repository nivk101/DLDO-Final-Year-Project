ADE simulation setup
Test DLDO_Simulations_DLDO_implementation_1: DLDO_Simulations/DLDO_implementation/config, simulator ams
  Models: /data/ibm/bicmos8hp/V1.6.0.0HP/Spectre/models/allModels.scs[tt], /data/ibm/bicmos8hp/V1.6.0.0HP/Spectre/models/design.scs, /data/ibm/bicmos8hp/V1.6.0.0HP/Spectre/models/wafer.scs
  Variables: wireopt = 211; current = 500u; Lswitch = 300n; Ltop = 1.4u; R = 0.1; R1 = 250; R2 = 1k; T = 1n; vref = 1; Wswitch = 32u; Wtop = 32u; vindc = 3; open = 50; close = open
  Temperature: 27
  Analysis tran: stop=4u
  Analysis dc: (saves the operating point)
  Output i /R0/PLUS; tran (I) = itime('tran "/R0/PLUS")
  Signals: /vout, /vfeedback, /net3, /vref<7:0>, /vin<7:0>, /hl, /CLK, /pulse, /bit<3:0>, /abs<7:0>, /in<7:0>, /gtz, /R0/PLUS (terminal), /R0/MINUS (terminal), /adcclk
Test DLDO_final: DLDO_final/DLDO_implementation/config, simulator ams
  Models: /data/ibm/bicmos8hp/V1.6.0.0HP/Spectre/models/allModels.scs[tt], /data/ibm/bicmos8hp/V1.6.0.0HP/Spectre/models/design.scs, /data/ibm/bicmos8hp/V1.6.0.0HP/Spectre/models/wafer.scs
  Variables: wireopt = 211; current = 500u; Lswitch = 300n; Ltop = 1.4u; R = 0.1; R1 = 250; R2 = 1k; T = 1n; vref = 1; Wswitch = 32u; Wtop = 32u; vindc = 3; open = 30; close = 40
  Temperature: 27
  Analysis dc: (saves the operating point)
  Analysis tran: stop=4u
  Output i /R0/PLUS; tran (I) = itime('tran "/R0/PLUS")
  Signals: /vout, /vfeedback, /net3, /vref<7:0>, /vin<7:0>, /hl, /CLK, /pulse, /bit<3:0>, /abs<7:0>, /in<7:0>, /gtz, /R0/PLUS (terminal), /R0/MINUS (terminal), /adcclk
